ADE simulation setup
Run mode: Single Run, Sweeps and Corners
Tests:
  labs_bonus_testbench_1: labs/bonus_testbench/config, simulator spectre
    Variables: vstep = 100m, 200m, 500m
