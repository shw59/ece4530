ADE simulation setup
Test labs_bonus_testbench_1: labs/bonus_testbench/config, simulator spectre
  Models: /opt/cadence-designkits/gpdk045_v_6_0/gpdk045/../models/spectre/gpdk045.scs[mc]
  Variables: vstep = 100m, 200m, 500m
  Temperature: 27
  Analysis tran: stop=30n errpreset=conservative
  Analysis ac: start=100K stop=100G dec=100
Run mode: Single Run, Sweeps and Corners
