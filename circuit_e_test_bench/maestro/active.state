ADE simulation setup
Test labs_circuit_e_test_bench_1: labs/circuit_e_test_bench/schematic, simulator spectre
  Models: /opt/cadence-designkits/gpdk045_v_6_0/gpdk045/../models/spectre/gpdk045.scs[mc]
  Temperature: 27.0
  Analysis tran: stop=100n errpreset=conservative
  Analysis dc: (saves the operating point)
  Analysis ac: start=100k stop=1T dec=100
Run mode: Single Run, Sweeps and Corners
