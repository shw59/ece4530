ADE simulation setup
Run mode: Single Run, Sweeps and Corners
Tests:
  labs_circuit_e_test_bench_1: labs/circuit_e_test_bench/schematic, simulator spectre
