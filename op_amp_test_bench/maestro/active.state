ADE simulation setup
Test labs_op_amp_test_bench_1: labs/op_amp_test_bench/schematic, simulator spectre
  Models: /opt/cadence-designkits/gpdk045_v_6_0/gpdk045/../models/spectre/gpdk045.scs[mc]
  Variables: amp_in = 10u:10u:300u; L = 2u; A_MAG = 1; I_AC = 0; I_DC = 0; Vbias = 1.25; N = 1; vdd = 2.5; W = 4u
  Temperature: 27
  Analysis dc: (saves the operating point)
  Analysis tran: stop=100m errpreset=conservative
  Analysis ac: start=1 stop=10G dec=100
Run mode: Single Run, Sweeps and Corners
Setup values for test labs_op_amp_test_bench_1: amp_in = 1u
