ADE simulation setup
Run mode: Single Run, Sweeps and Corners
Tests:
  labs_op_amp_test_bench_1: labs/op_amp_test_bench/schematic, simulator spectre
    Variables: N = 1; vdd = 2.5; W = 4u; Vbias = 1.25; I_AC = 0; I_DC = 0; A_MAG = 1; L = 2u; amp_in = 10u:10u:300u
