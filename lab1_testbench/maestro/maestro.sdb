ADE simulation setup
Run mode: Single Run, Sweeps and Corners
Tests:
  labs_lab1_testbench_1: labs/lab1_testbench/schematic, simulator spectre
