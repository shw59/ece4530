ADE simulation setup
Test labs_nfet_1: labs/nfet/schematic, simulator spectre
  Models: /opt/cadence-designkits/gpdk045_v_6_0/gpdk045/../models/spectre/gpdk045.scs[mc]
  Variables: vgs = 700m; vds = 700m
  Temperature: 27.0
  Analysis tran: stop=15n errpreset=conservative
  Analysis ac: start=1M stop=1T dec=20
  Analysis dc: sweep vds start=0 stop=1 step=10m (saves the operating point)
Run mode: Single Run, Sweeps and Corners
