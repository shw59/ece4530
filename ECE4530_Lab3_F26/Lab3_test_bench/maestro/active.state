ADE simulation setup
Test ECE4530_2026_MP2_test_bench_1: lab3/Lab3_test_bench/schematic, simulator spectre
  Models: /opt/cadence-designkits/gpdk045_v_6_0/gpdk045/../models/spectre/gpdk045.scs[mc]
  Variables: N = 1; AC_CM = 1; AC_DM = 0; F1 = 1M; F2 = 500M; Vbias = 1.25; vdd = 2.4; W = 2u
  Temperature: 27
  Analysis tran: stop=5u errpreset=conservative
  Analysis dc: (saves the operating point)
  Analysis ac: start=10k stop=1G
Run mode: Single Run, Sweeps and Corners
Setup values for test ECE4530_2026_MP2_test_bench_1: AC_CM = 0; AC_DM = 1; F2 = 50M
