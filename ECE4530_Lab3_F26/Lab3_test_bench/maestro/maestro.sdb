ADE simulation setup
Run mode: Single Run, Sweeps and Corners
Tests:
  ECE4530_2026_MP2_test_bench_1: lab3/Lab3_test_bench/schematic, simulator spectre
    Variables: AC_CM = 0; AC_DM = 1; F1 = 100k; F2 = 500M; Vbias = 1.25; vdd = 2.4; N = 1; W = 2u
