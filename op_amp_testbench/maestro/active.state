ADE simulation setup
Test labs_lab1_testbench_1: labs/op_amp_testbench/config, simulator spectre
  Models: /opt/cadence-designkits/gpdk045_v_6_0/gpdk045/../models/spectre/gpdk045.scs[mc]
  Variables: vstep = 50m, 200m
  Temperature: 27.0
  Analysis tran: stop=15n errpreset=conservative
  Analysis ac: start=100k stop=100G dec=100
  Analysis dc: (saves the operating point)
Run mode: Single Run, Sweeps and Corners
