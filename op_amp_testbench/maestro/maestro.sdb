ADE simulation setup
Run mode: Single Run, Sweeps and Corners
Tests:
  labs_lab1_testbench_1: labs/op_amp_testbench/config, simulator spectre
    Variables: vstep = 50m, 200m
