ADE simulation setup
Run mode: Single Run, Sweeps and Corners
Tests:
  labs_rect_block_test_bench_1: labs/rect_block_test_bench/schematic, simulator spectre
    Variables: F = 50k
