ADE simulation setup
Test labs_rect_block_test_bench_1: labs/rect_block_test_bench/schematic, simulator spectre
  Models: /opt/cadence-designkits/gpdk045_v_6_0/gpdk045/../models/spectre/gpdk045.scs[mc]
  Variables: F = 50k
  Temperature: 27
  Analysis dc: (saves the operating point)
  Analysis tran: stop=100u errpreset=conservative
  Analysis ac: start=10k stop=1G dec=100
Run mode: Single Run, Sweeps and Corners
